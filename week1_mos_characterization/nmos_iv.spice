** sch_path: /foss/designs/sky130-analog-design/week1_mos_characterization/nmos_iv.sch
**.subckt nmos_iv
XM2 net2 net1 0 0 sky130_fd_pr__nfet_01v8 L=0.15 W=1 nf=1 ad=0.29 as=0.29 pd=2.58 ps=2.58 nrd=0.29 nrs=0.29 sa=0 sb=0 sd=0 mult=1
Vgs net1 0 0.9
Vds net2 0 0.9
**** begin user architecture code

.lib /foss/pdks/sky130A/libs.tech/ngspice/sky130.lib.spice tt
.dc Vds 0 1.8 0.01 Vgs 0.4 1.8 0.2
.control
run
plot -i(Vds)
.endc

**** end user architecture code
**.ends
.end
